* SPICE NETLIST
***************************************

.SUBCKT crtmom PLUS MINUS BULK
.ENDS
***************************************
.SUBCKT crtmom_rf PLUS MINUS BULK
.ENDS
***************************************
.SUBCKT cfmom PLUS MINUS BULK
.ENDS
***************************************
.SUBCKT cfmom_rf PLUS MINUS BULK
.ENDS
***************************************
.SUBCKT cfmom_mx PLUS1 MINUS1 PLUS2 MINUS2 BULK
.ENDS
***************************************
.SUBCKT efuse PLUS MINUS
.ENDS
***************************************
.SUBCKT hvpwdnwhvnw_dio_hvpw_3t PLUS MINUS SUB
.ENDS
***************************************
.SUBCKT lcesd1_rf PLUS MINUS
.ENDS
***************************************
.SUBCKT lcesd2_rf PLUS MINUS
.ENDS
***************************************
.SUBCKT lowcpad_rf APAD AVSS
.ENDS
***************************************
.SUBCKT lvpwdnwhvnw_dio_hvpw_3t PLUS MINUS SUB
.ENDS
***************************************
.SUBCKT mimcap_1p0_sin TOP BOT
.ENDS
***************************************
.SUBCKT mimcap_1p0_sin_3t PLUS MINUS BULK
.ENDS
***************************************
.SUBCKT mimcap_1p0_sin_hl TOP BOT
.ENDS
***************************************
.SUBCKT mimcap_1p0_sin_hl_3t PLUS MINUS BULK
.ENDS
***************************************
.SUBCKT mimcap_1p5_sin TOP BOT
.ENDS
***************************************
.SUBCKT mimcap_1p5_sin_3t PLUS MINUS BULK
.ENDS
***************************************
.SUBCKT mimcap_2p0_shield PLUS MINUS BULK
.ENDS
***************************************
.SUBCKT mimcap_2p0_sin TOP BOT
.ENDS
***************************************
.SUBCKT mimcap_2p0_sin_3ds TOP BOTTOM
.ENDS
***************************************
.SUBCKT mimcap_2p0_sin_3ds_3t TOP BOTTOM GNODE
.ENDS
***************************************
.SUBCKT mimcap_2p0_sin_3t PLUS MINUS BULK
.ENDS
***************************************
.SUBCKT mimcap_2p0_wos PLUS MINUS BULK
.ENDS
***************************************
.SUBCKT mimcap_4p0_sin_3dshs TOP BOTTOM
.ENDS
***************************************
.SUBCKT mimcap_4p0_sin_3dshs_3t TOP BOTTOM GNODE
.ENDS
***************************************
.SUBCKT mimcap_shield PLUS MINUS BULK
.ENDS
***************************************
.SUBCKT mimcap_wos PLUS MINUS BULK
.ENDS
***************************************
.SUBCKT moscap_rf33 PLUS MINUS BULK
.ENDS
***************************************
.SUBCKT moscap_rf33_nw PLUS MINUS BULK
.ENDS
***************************************
.SUBCKT moscap_rf PLUS MINUS BULK
.ENDS
***************************************
.SUBCKT moscap_rf_nw PLUS MINUS BULK
.ENDS
***************************************
.SUBCKT nch_hv5_5vnw_ac D G S B
.ENDS
***************************************
.SUBCKT LDDN D G S B
.ENDS
***************************************
.SUBCKT nch_hva_mac D G S B
.ENDS
***************************************
.SUBCKT nch_hva_ndd_mac D G S B
.ENDS
***************************************
.SUBCKT nch_hvau_ndd_mac D G S B
.ENDS
***************************************
.SUBCKT nch_hvi_mac D G BS SUB
.ENDS
***************************************
.SUBCKT nch_hviah_ndd_mac D G S B
.ENDS
***************************************
.SUBCKT nch_hvish_nbl_mac D G S B NBL_ISO SUB
.ENDS
***************************************
.SUBCKT nch_hvish_ndd_mac D G S B
.ENDS
***************************************
.SUBCKT nch_hvisl_mac D G S B
.ENDS
***************************************
.SUBCKT nch_hvnw_6t D G S B HVNW_ISO SUB
.ENDS
***************************************
.SUBCKT nch_hvs_mac D G S B
.ENDS
***************************************
.SUBCKT nch_hvs_ndd_mac D G S B
.ENDS
***************************************
.SUBCKT nch_hvsl_mac D G S B
.ENDS
***************************************
.SUBCKT nch_hvsu_ndd_mac D G S B
.ENDS
***************************************
.SUBCKT ndio_hia_rf PLUS MINUS
.ENDS
***************************************
.SUBCKT ndio_sbd_mac PLUS MINUS
.ENDS
***************************************
.SUBCKT ndld24_g5_ac D G BS SUB
.ENDS
***************************************
.SUBCKT ndld40_g5_ac D G BS SUB
.ENDS
***************************************
.SUBCKT nhvpwdnw10_4t C B E SUB
.ENDS
***************************************
.SUBCKT nhvpwdnw5_4t C B E SUB
.ENDS
***************************************
.SUBCKT nld12_g12_mac D G BS SUB
.ENDS
***************************************
.SUBCKT nld12_g2_mac D G BS SUB
.ENDS
***************************************
.SUBCKT nld14_g12_mac D G BS SUB
.ENDS
***************************************
.SUBCKT nld14_g2_mac D G BS SUB
.ENDS
***************************************
.SUBCKT nld18_g5_ac D G BS SUB
.ENDS
***************************************
.SUBCKT nld24_g5_ac D G BS SUB
.ENDS
***************************************
.SUBCKT nld32_g5_ac D G BS SUB
.ENDS
***************************************
.SUBCKT nld40_g5_ac D G BS SUB
.ENDS
***************************************
.SUBCKT nld60_g5_ac D G BS SUB
.ENDS
***************************************
.SUBCKT nmos_rf D G S B
.ENDS
***************************************
.SUBCKT nmos_rf33 D G S B
.ENDS
***************************************
.SUBCKT nmos_rf33_6t D G S B NG PG
.ENDS
***************************************
.SUBCKT nmos_rf_6t D G S B NG PG
.ENDS
***************************************
.SUBCKT nmoscap PLUS MINUS
.ENDS
***************************************
.SUBCKT nmoscap_33 PLUS MINUS
.ENDS
***************************************
.SUBCKT nmoscap_33_mis PLUS MINUS
.ENDS
***************************************
.SUBCKT nmoscap_mis PLUS MINUS
.ENDS
***************************************
.SUBCKT nvmrpodrpo_m PLUS MINUS B
.ENDS
***************************************
.SUBCKT LDDP D G S B
.ENDS
***************************************
.SUBCKT pa18_g5_ac D G S B SUB
.ENDS
***************************************
.SUBCKT pa24_g5_ac D G S B SUB
.ENDS
***************************************
.SUBCKT pa32_g5_ac D G S B SUB
.ENDS
***************************************
.SUBCKT pa40_g5_full_soa_ac D G S B SUB
.ENDS
***************************************
.SUBCKT pa40_g5_low_ron_ac D G S B SUB
.ENDS
***************************************
.SUBCKT pa50_g5_ac D G S B SUB
.ENDS
***************************************
.SUBCKT pa60_g5_full_soa_ac D G S B SUB
.ENDS
***************************************
.SUBCKT pch_5t D G S B SUB
.ENDS
***************************************
.SUBCKT pch_hva_mac D G S B SUB
.ENDS
***************************************
.SUBCKT pch_hva_pdd_mac D G S B
.ENDS
***************************************
.SUBCKT pch_hvau_pdd_mac D G S B
.ENDS
***************************************
.SUBCKT pch_hvs_mac D G S B SUB
.ENDS
***************************************
.SUBCKT pch_hvs_pdd_mac D G S B
.ENDS
***************************************
.SUBCKT pch_hvsl_mac D G S B
.ENDS
***************************************
.SUBCKT pch_hvsu_pdd_mac D G S B
.ENDS
***************************************
.SUBCKT pdio_hia_rf PLUS MINUS BULK
.ENDS
***************************************
.SUBCKT phvnw_dio_hvpw_3t PLUS MINUS SUB
.ENDS
***************************************
.SUBCKT pmos_rf D G S B
.ENDS
***************************************
.SUBCKT pmos_rf33 D G S B
.ENDS
***************************************
.SUBCKT pmos_rf33_5t D G S B PG
.ENDS
***************************************
.SUBCKT pmos_rf33_nw D G S B
.ENDS
***************************************
.SUBCKT pmos_rf33_nw_5t D G S B PG
.ENDS
***************************************
.SUBCKT pmos_rf_5t D G S B PG
.ENDS
***************************************
.SUBCKT pmos_rf_nw D G S B
.ENDS
***************************************
.SUBCKT pmos_rf_nw_5t D G S B PG
.ENDS
***************************************
.SUBCKT rhim PLUS MINUS
.ENDS
***************************************
.SUBCKT rhvnw PLUS MINUS BULK
.ENDS
***************************************
.SUBCKT rhvnw_60 PLUS MINUS BULK
.ENDS
***************************************
.SUBCKT rhvnwhvpw PLUS MINUS BULK
.ENDS
***************************************
.SUBCKT rhvpw PLUS MINUS BULK
.ENDS
***************************************
.SUBCKT rhvpw_60 PLUS MINUS BULK
.ENDS
***************************************
.SUBCKT rldpwod PLUS MINUS BULK
.ENDS
***************************************
.SUBCKT rldpwsti PLUS MINUS BULK
.ENDS
***************************************
.SUBCKT rnddhvpw PLUS MINUS BULK
.ENDS
***************************************
.SUBCKT rnod_m PLUS MINUS B
.ENDS
***************************************
.SUBCKT rnodrpo_m PLUS MINUS B
.ENDS
***************************************
.SUBCKT rnodw_m PLUS MINUS B
.ENDS
***************************************
.SUBCKT rnpo1_dis PLUS MINUS B
.ENDS
***************************************
.SUBCKT rnpo1rpo_dis PLUS MINUS B
.ENDS
***************************************
.SUBCKT rnpo1w_dis PLUS MINUS B
.ENDS
***************************************
.SUBCKT rnwod_ell PLUS MINUS
.ENDS
***************************************
.SUBCKT rnwod_ell_m PLUS MINUS B
.ENDS
***************************************
.SUBCKT rnwod_m PLUS MINUS B
.ENDS
***************************************
.SUBCKT rnwod_ull PLUS MINUS
.ENDS
***************************************
.SUBCKT rnwod_ull_m PLUS MINUS B
.ENDS
***************************************
.SUBCKT rnwsti_ell PLUS MINUS
.ENDS
***************************************
.SUBCKT rnwsti_ell_m PLUS MINUS B
.ENDS
***************************************
.SUBCKT rnwsti_m PLUS MINUS B
.ENDS
***************************************
.SUBCKT rnwsti_ull PLUS MINUS
.ENDS
***************************************
.SUBCKT rnwsti_ull_m PLUS MINUS B
.ENDS
***************************************
.SUBCKT rpbody PLUS MINUS BULK
.ENDS
***************************************
.SUBCKT rpddhvnw PLUS MINUS BULK
.ENDS
***************************************
.SUBCKT rpod_ell PLUS MINUS
.ENDS
***************************************
.SUBCKT rpod_ell_m PLUS MINUS B
.ENDS
***************************************
.SUBCKT rpod_m PLUS MINUS B
.ENDS
***************************************
.SUBCKT rpod_ull PLUS MINUS
.ENDS
***************************************
.SUBCKT rpod_ull_m PLUS MINUS B
.ENDS
***************************************
.SUBCKT rpodrpo_ell PLUS MINUS
.ENDS
***************************************
.SUBCKT rpodrpo_ell_m PLUS MINUS B
.ENDS
***************************************
.SUBCKT rpodrpo_m PLUS MINUS B
.ENDS
***************************************
.SUBCKT rpodrpo_ull PLUS MINUS
.ENDS
***************************************
.SUBCKT rpodrpo_ull_m PLUS MINUS B
.ENDS
***************************************
.SUBCKT rpodw_ell PLUS MINUS
.ENDS
***************************************
.SUBCKT rpodw_ell_m PLUS MINUS B
.ENDS
***************************************
.SUBCKT rpodw_m PLUS MINUS B
.ENDS
***************************************
.SUBCKT rpodw_ull PLUS MINUS
.ENDS
***************************************
.SUBCKT rpodw_ull_m PLUS MINUS B
.ENDS
***************************************
.SUBCKT rppo1_dis PLUS MINUS B
.ENDS
***************************************
.SUBCKT rppo1rpo_dis PLUS MINUS B
.ENDS
***************************************
.SUBCKT rppo1w_dis PLUS MINUS B
.ENDS
***************************************
.SUBCKT rppolyhri3k PLUS MINUS
.ENDS
***************************************
.SUBCKT rppolyhri3k_dis PLUS MINUS BULK
.ENDS
***************************************
.SUBCKT rppolyhri_dis PLUS MINUS B
.ENDS
***************************************
.SUBCKT rppolyhri_rf PLUS MINUS BULK
.ENDS
***************************************
.SUBCKT rppolyl_rf PLUS MINUS BULK
.ENDS
***************************************
.SUBCKT rppolys_rf PLUS MINUS BULK
.ENDS
***************************************
.SUBCKT rppolywo_rf PLUS MINUS BULK
.ENDS
***************************************
.SUBCKT sbd_dio_60 PLUS MINUS
.ENDS
***************************************
.SUBCKT sbd_rf PLUS MINUS BULK
.ENDS
***************************************
.SUBCKT sbd_rf_nw PLUS MINUS BULK
.ENDS
***************************************
.SUBCKT xjvar_nr36 PLUS MINUS BULK
.ENDS
***************************************
.SUBCKT xjvar_w40 PLUS MINUS BULK
.ENDS
***************************************
.SUBCKT zd_dio_4t PLUS MINUS NBL_ISO SUB
.ENDS
***************************************
.SUBCKT NAND2 B A VSS VDD OUT
** N=6 EP=5 IP=0 FDC=4
* PORT B B 1100 6400 metal2
* PORT A A 1350 7400 metal2
* PORT VSS VSS 450 2600 metal1
* PORT VDD VDD 200 15400 metal1
* PORT OUT OUT 3400 8300 metal1
M0 6 B VSS VSS N L=1.8e-07 W=1e-06 AD=4.1e-13 AS=6.1e-13 PD=1.82e-06 PS=3.22e-06 NRD=0.41 NRS=0.61 sa=6.1e-07 sb=1.71e-06 sca=0.66101 scb=3.65108e-08 scc=3.04642e-15 $X=1610 $Y=3400 $D=3
M1 OUT A 6 VSS N L=1.8e-07 W=1e-06 AD=7.1e-13 AS=4.1e-13 PD=3.42e-06 PS=1.82e-06 NRD=0.71 NRS=0.41 sa=1.61e-06 sb=7.1e-07 sca=0.680155 scb=4.35081e-08 scc=3.12046e-15 $X=2610 $Y=3400 $D=3
M2 OUT B VDD VDD P L=1.8e-07 W=4e-06 AD=1.64e-12 AS=2.44e-12 PD=4.82e-06 PS=9.22e-06 NRD=0.1025 NRS=0.1525 sa=6.1e-07 sb=1.91e-06 sca=1.03416 scb=6.37064e-06 scc=1.91336e-10 $X=1610 $Y=9900 $D=39
M3 VDD A OUT VDD P L=1.8e-07 W=4e-06 AD=3.64e-12 AS=1.64e-12 PD=9.82e-06 PS=4.82e-06 NRD=0.2275 NRS=0.1025 sa=1.61e-06 sb=9.1e-07 sca=0.872681 scb=3.28759e-06 scc=1.80888e-10 $X=2610 $Y=9900 $D=39
.ENDS
***************************************
